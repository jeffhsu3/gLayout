.subckt NMOS D G S B l=1.0u w=2.0u m=2 dm=1
XMAIN   D G S B nfet_03v3 l={l} w={w} m={m}
XDUMMY1 B B B B nfet_03v3 l={l} w={w} m={dm}
.ends NMOS

.subckt DIFF_PAIR VP VN VDD1 VDD2 VTAIL B
X0 VDD1 VP VTAIL B NMOS l=1.0u w=2.0u m=1 dm=1
X1 VDD2 VN VTAIL B NMOS l=1.0u w=2.0u m=1 dm=1
.ends DIFF_PAIR

.subckt CMIRROR VREF VCOPY VSS VB l=4.0u w=2.0u m=1
XA VREF VREF VSS VB nfet_03v3 l={l} w={w} m={m}
XB VCOPY VREF VSS VB nfet_03v3 l={l} w={w} m={m}
.ends CMIRROR

.subckt NMOS_1 D G S B l=0.5u w=1u m=2 dm=1
XMAIN   D G S B nfet_03v3 l={l} w={w} m={m}
.ends NMOS_1

.subckt INPUT_STAGE VP VN VDD1 VDD2 IBIAS VSS B
X0 VP VN VDD1 VDD2 wire0 B DIFF_PAIR
X1 IBIAS wire0 VSS VSS CMIRROR l=4.0u w=2.0u m=2
X2 VSS VSS VP VSS NMOS_1 l=0.5u w=1u m=1 dm=1
X3 VSS VSS VN VSS NMOS_1 l=0.5u w=1u m=1 dm=1
.ends INPUT_STAGE

.subckt DIFF_TO_SINGLE VIN VOUT VSS VSS2 l=1.0u w=2.0u mt=8 mb=8
XTOP1 V1   VIN VSS  VSS pfet_03v3 l={l} w={w} m={mt}
XTOP2 VSS2 VIN VSS  VSS pfet_03v3 l={l} w={w} m={mt}
XBOT1 VIN  VIN V1   VSS pfet_03v3 l={l} w={w} m={mb}
XBOT2 VOUT VIN VSS2 VSS pfet_03v3 l={l} w={w} m={mb}
.ends DIFF_TO_SINGLE

.subckt PMOS D G S B l=1.0u w=3.0u m=8 dm=2
XMAIN   D G S B pfet_03v3 l={l} w={w} m={m}
XDUMMY1 B B B B pfet_03v3 l={l} w={w} m={dm}
XDUMMY2 B B B B pfet_03v3 l={l} w={w} m={dm}
.ends PMOS

.subckt DIFF_TO_SINGLE_CS VIN1 VIN2 VOUT VSS VSS2
X0 VIN1 VIN2 VSS VSS2 DIFF_TO_SINGLE l=1.0u w=2.0u mt=8 mb=8
X1 VOUT VIN2 VSS VSS PMOS l=1.0u w=3.0u m=1 dm=2
X2 VOUT VIN2 VSS VSS PMOS l=1.0u w=3.0u m=1 dm=2
.ends DIFF_TO_SINGLE_CS

.subckt MIMCap V1 V2 l=1u w=1u
X1 V1 V2 cap_mim_2f0_m4m5_noshield l={l} w={w}
.ends MIMCap

.subckt MIMCAP_ARR V1 V2
X0 V1 V2 MIMCap l=6.0u w=6.0u
X1 V1 V2 MIMCap l=6.0u w=6.0u
.ends MIMCAP_ARR

.subckt GAIN_STAGE VIN1 VIN2 VOUT VDD IBIAS GND
X0 VIN1 VIN2 VOUT VDD wire0 DIFF_TO_SINGLE_CS
X1 IBIAS VOUT GND GND CMIRROR l=4.0u w=2.0u m=2
X2 VOUT wire0 MIMCAP_ARR
.ends GAIN_STAGE

.subckt OPAMP_TWO_STAGE VDD GND DIFFPAIR_BIAS VP VN CS_BIAS VOUT
X0 VP VN wire0 wire1 DIFFPAIR_BIAS GND GND INPUT_STAGE
X1 wire0 wire1 VOUT VDD CS_BIAS GND GAIN_STAGE
.ends OPAMP_TWO_STAGE

.subckt diff_buffer VINP VINN VOUTP VOUTN VDP_BIAS VCS_BIAS VDD VSS
X0 VDD VSS VDP_BIAS VOUTP VINP VCS_BIAS VOUTP OPAMP_TWO_STAGE
X1 VDD VSS VDP_BIAS VOUTN VINN VCS_BIAS VOUTN OPAMP_TWO_STAGE
.ends diff_buffer
